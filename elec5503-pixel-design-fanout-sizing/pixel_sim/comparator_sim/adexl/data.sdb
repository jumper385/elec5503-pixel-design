ADE simulation setup
Run mode: Single Run, Sweeps and Corners
Tests:
  pixel_sim:comparator_sim:1: pixel_sim/comparator_sim/schematic, simulator spectre
    Outputs: cross(VDC("OUT") 0.6 1 "either" nil nil) [V]
Global variables:
  Vb = 0
  Va = 0
  w_a = 0.323
  w_b = 0.142
  w_base = 0.453
  w_nmos = 1
  w_nandab = 0.03:0.001:0.06
  w_ = {Inclusion List}1{Inclusion List} (off)
Specs:
  pixel_sim:comparator_sim:1 / cross(VDC("OUT") 0.6 1 "either" nil nil): range 0.59 to 0.61, weight 100
