ADE simulation setup
Run mode: Local Optimization
Tests:
  pixel_sim:comparator_sim:1: pixel_sim/comparator_sim/schematic, simulator spectre
    Variables: Va = 0:1.2:1.2; Vb = 0:1.2:1.2; w_a = 0.323; w_nandab = 0.03:0.001:0.06; w_base = 0.453; w_b = 0.142; w_nmos = 1; u = 1e-6
Global variables:
  w_a = 3
  w_nandab = 1
  w_nmos = 1
  w_base = 1
  w_b = 1
  u = 1e-6
