ADE simulation setup
Run mode: Single Run, Sweeps and Corners
Tests:
  pixel_sim:comparator_ac_sim:TG00: pixel_sim/comparator_ac_sim/schematic, simulator spectre
    Variables: Va = 0; Vb = 0
Device parameters:
  pixel_sim/comparator_ac_sim/schematic/V4.tr = {From/To}LinearStepCount:1n:20:20n{From/To}
  pixel_sim/comparator_ac_sim/schematic/C0.c = 0f
