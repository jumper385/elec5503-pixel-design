ADE simulation setup
Run mode: Single Run, Sweeps and Corners
Tests:
  pixel_sim:comparator_ac_sim:TG00: pixel_sim/comparator_ac_sim/schematic, simulator spectre
    Variables: Va = 0; Vb = 0
  pixel_sim:comparator_ac_sim:TG01: pixel_sim/comparator_ac_sim/schematic, simulator spectre
    Variables: Va = 0; Vb = 1.2
  pixel_sim:comparator_ac_sim:TG10: pixel_sim/comparator_ac_sim/schematic, simulator spectre
    Variables: Va = 1.2; Vb = 0
  pixel_sim:comparator_ac_sim:TG11: pixel_sim/comparator_ac_sim/schematic, simulator spectre
    Variables: Va = 1.2; Vb = 1.2
Device parameters:
  pixel_sim/comparator_ac_sim/schematic/V4.tr = {From/To}Decade:50n:10:100u{From/To}
  pixel_sim/comparator_ac_sim/schematic/C0.c = 20f
