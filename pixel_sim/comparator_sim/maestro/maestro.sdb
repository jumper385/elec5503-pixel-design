ADE simulation setup
Run mode: Single Run, Sweeps and Corners
Tests:
  pixel_sim:comparator_sim:1 (off): pixel_sim/comparator_sim/schematic, simulator spectre
    Outputs: cross(VDC("OUT") 0.6 1 "either" nil nil) [V]
  pixel_sim:comparator_sim:TG00: pixel_sim/comparator_sim/schematic, simulator spectre
    Variables: Va = 0; Vb = 0
  pixel_sim:comparator_sim:TG01: pixel_sim/comparator_sim/schematic, simulator spectre
    Variables: Va = 0; Vb = 1.2
    Outputs: slewRate(VDC("/OUT") 0 t 1.2 t 10 90 nil "time")
  pixel_sim:comparator_sim:TG10: pixel_sim/comparator_sim/schematic, simulator spectre
    Variables: Va = 1.2; Vb = 0
    Outputs: slewRate(VDC("/OUT") 0 t 1.2 t 10 90 nil "time")
  pixel_sim:comparator_sim:TG11: pixel_sim/comparator_sim/schematic, simulator spectre
    Variables: Va = 1.2; Vb = 1.2
    Outputs: slewRate(VDC("/OUT") 0 t 1.2 t 10 90 nil "time")
Device parameters:
  pixel_sim/comparator_sim/schematic/I4.w_base = 0.453 (off)
  pixel_sim/comparator_sim/schematic/I4.w_nandab = 0.04 (off)
  pixel_sim/comparator_sim/schematic/I4.w_b = 0.142 (off)
  pixel_sim/comparator_sim/schematic/I4.w_a = 0.323 (off)
Specs:
  pixel_sim:comparator_sim:1 / cross(VDC("OUT") 0.6 1 "either" nil nil): range 0.59 to 0.61, weight 100
  pixel_sim:comparator_sim:TG00 / cross(VDC("/OUT") 0.6 1 "rising" nil nil): range 590m to 610m
  pixel_sim:comparator_sim:TG01 / cross(VDC("/OUT") 0.6 1 "rising" nil nil): range 545m to 555m
  pixel_sim:comparator_sim:TG10 / cross(VDC("/OUT") 0.6 1 "rising" nil nil): range 495m to 505m
  pixel_sim:comparator_sim:TG11 / cross(VDC("/OUT") 0.6 1 "rising" nil nil): range 445m to 455m
