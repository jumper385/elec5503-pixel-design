ADE simulation setup
Run mode: Single Run, Sweeps and Corners
Tests:
  pixel_sim:integration_sim:1: pixel_sim/integration_sim/schematic, simulator spectre
