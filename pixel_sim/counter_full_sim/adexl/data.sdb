ADE simulation setup
Run mode: Single Run, Sweeps and Corners
Tests:
  pixel_sim:counter_full_sim:1: pixel_sim/counter_full_sim/schematic, simulator spectre
