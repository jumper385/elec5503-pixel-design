ADE simulation setup
Run mode: Single Run, Sweeps and Corners
Tests:
  pixel_sim:counter_full_sim:1 (off): pixel_sim/counter_full_sim/schematic, simulator spectre
  pixel_sim:counter_full_sim:2: pixel_sim/counter_full_sim/schematic_PT, simulator spectre
