ADE simulation setup
Run mode: Single Run, Sweeps and Corners
Tests:
  pixel_sim:delay_chain_sim:1: pixel_sim/delay_chain_sim/schematic, simulator spectre
  pixel_sim:delay_chain_sim:2: pixel_sim/delay_chain_sim/schematic, simulator spectre
