ADE simulation setup
Run mode: Single Run, Sweeps and Corners
Tests:
  pixel_sim:DCinv_SIM:1: pixel_sim/DCinv_SIM/schematic, simulator spectre
  pixel_sim:DCinv_SIM:2: pixel_sim/DCinv_SIM/schematic, simulator spectre
