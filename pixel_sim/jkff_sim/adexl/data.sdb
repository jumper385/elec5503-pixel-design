ADE simulation setup
Run mode: Single Run, Sweeps and Corners
Tests:
  pixel_sim:jkff_sim:1: pixel_sim/jkff_sim/schematic, simulator spectre
