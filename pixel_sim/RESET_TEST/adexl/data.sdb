ADE simulation setup
Run mode: Single Run, Sweeps and Corners
Tests:
  pixel_sim:RESET_TEST:1: pixel_sim/RESET_TEST/config, simulator spectre
