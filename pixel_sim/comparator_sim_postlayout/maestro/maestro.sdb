ADE simulation setup
Run mode: Single Run, Sweeps and Corners
Tests:
  pixel_sim:comparator_sim:TG00: pixel_sim/comparator_sim/config, simulator spectre
    Variables: Va = 0; Vb = 0
    Outputs: cross(VDC("/OUT") 0.6 1 "rising" nil nil)
  pixel_sim:comparator_sim:TG01: pixel_sim/comparator_sim/config, simulator spectre
    Variables: Va = 0; Vb = 1.2
    Outputs: cross(VDC("/OUT") 0.6 1 "rising" nil nil)
  pixel_sim:comparator_sim:TG10: pixel_sim/comparator_sim/config, simulator spectre
    Variables: Va = 1.2; Vb = 0
    Outputs: cross(VDC("/OUT") 0.6 1 "rising" nil nil)
  pixel_sim:comparator_sim:TG11: pixel_sim/comparator_sim/config, simulator spectre
    Variables: Va = 1.2; Vb = 1.2
    Outputs: cross(VDC("/OUT") 0.6 1 "rising" nil nil)
Global variables:
  Va = 0 (off)
  Vb = 0 (off)
Device parameters:
  pixel_sim/comparator_sim/schematic/V1.vdc = Va
  pixel_sim/comparator_sim/schematic/V2.vdc = Vb
Specs:
  pixel_sim:comparator_sim:TG00 / cross(VDC("/OUT") 0.6 1 "rising" nil nil): range 590m to 610m
  pixel_sim:comparator_sim:TG01 / cross(VDC("/OUT") 0.6 1 "rising" nil nil): range 545m to 555m
  pixel_sim:comparator_sim:TG10 / cross(VDC("/OUT") 0.6 1 "rising" nil nil): range 495m to 505m
  pixel_sim:comparator_sim:TG11 / cross(VDC("/OUT") 0.6 1 "rising" nil nil): range 445m to 455m
