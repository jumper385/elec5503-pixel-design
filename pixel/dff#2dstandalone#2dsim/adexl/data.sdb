ADE simulation setup
Run mode: Single Run, Sweeps and Corners
Tests:
  pixel:dff-standalone-sim:1: pixel/dff-standalone-sim/schematic, simulator spectre
